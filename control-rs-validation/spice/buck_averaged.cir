* ==============================================================================
* BUCK CONVERTER AVERAGED CIRCUIT SIMULATION (ngspice)
* Documentation: documentation/control-toolboxes/classical-tools-design.md, §6.6
*
* Circuit Parameters:
*   V_in = 12.0 V, V_out = 5.0 V, D0 = 5/12 = 0.4166667
*   L = 100 uH, C = 100 uF, R_load = 1.0 Ohm (Nominal I_out = 5.0 A)
*
* Lead Compensator C(s) = K * (s + 1/T) / (s + 1/(alpha*T)):
*   K = 1.351654, T = 6.328e-5 s, alpha = 0.27748
*   Passive stage: R1 = 10 kOhm, C1 = 6.328 nF, R2 = 3840.4 Ohm (DC atten = alpha)
*   Gain stage: E_gain = K = 1.351654 (DC gain = K*alpha = 0.3751, HF gain = K = 1.3517)
* ==============================================================================

.title Buck Converter Averaged Small/Large Signal Simulation

* ------------------------------------------------------------------------------
* Circuit Power Stage (Averaged Switch Model)
* ------------------------------------------------------------------------------
V_in in 0 DC 12.0

* Switch node voltage is duty cycle times rail voltage: v_sw = d * V_in
B_sw sw 0 V = V(d) * V(in)

L_filt sw out 100u ic=5.0
C_filt out 0 100u ic=5.0

* Nominal 1 Ohm load, switchable to 2 Ohm at t=1ms for load step
Rload1 out 0 2.0
Rload2 out sw_load 2.0
S_load sw_load 0 ctrl_load 0 SW_LOAD
V_ctrl_load ctrl_load 0 PULSE(1 0 1.0m 1u 1u 5m 10m)
.model SW_LOAD SW(Ron=1m Roff=1Meg Vt=0.5)

* ------------------------------------------------------------------------------
* Feedback & Lead Compensator Network
* ------------------------------------------------------------------------------
* Reference setpoint: 5.0 V stepping to 5.5 V at t=0.5ms (for setpoint step test)
V_ref ref 0 PULSE(5.0 5.5 0.5m 1u 1u 5m 10m)

* Error amplifier: e(t) = V_ref - V_out
E_err err 0 ref out 1.0

* Analog Lead Network:
* Rcomp1 || Ccomp in series with Rcomp2 forms the passive lead divider
Rcomp1 err n_lead 10000.0
Ccomp err n_lead 6.328n
Rcomp2 n_lead 0 3840.4
* Gain amplifier stage:
E_gain d_hat 0 n_lead 0 1.351654

* Duty cycle command: d(t) = clamp(D0 + d_hat, 0.0, 1.0)
B_d d 0 V = min(max(0.4166666666666667 + V(d_hat), 0.0), 1.0)

* ------------------------------------------------------------------------------
* Open-Loop Small-Signal Plant for AC Analysis
* ------------------------------------------------------------------------------
* Uncoupled auxiliary stage for isolated plant Bode response:
V_d_ac d_ac 0 DC 0.4166666666666667 AC 1.0
B_sw_ac sw_ac 0 V = V(d_ac) * 12.0
L_ac sw_ac out_ac 100u
C_ac out_ac 0 100u
Rload_ac out_ac 0 1.0

* ------------------------------------------------------------------------------
* Control Script (AC, Setpoint Step, and Load Step)
* ------------------------------------------------------------------------------
.control
set filetype=ascii

* 1. Small-signal AC plant sweep (15.9 Hz to 159 kHz = 100 rad/s to 1 Mrad/s)
ac dec 100 15.915494 159154.94
wrdata results/ngspice_ac_plant.txt vdb(out_ac) vp(out_ac)

* 2. Closed-loop setpoint step transient (Rload = 1.0 Ohm fixed, V_ref steps 5.0 -> 5.5V)
* Temporarily force load switch ON to maintain Rload = 1.0 Ohm throughout
alter V_ctrl_load pulse = [ 1 1 0 0 0 10m 20m ]
tran 1u 3m uic
wrdata results/ngspice_step.txt v(out) v(d) i(L_filt)

* 3. Closed-loop load disturbance transient (V_ref = 5.0V fixed, Rload steps 1.0 -> 2.0 Ohm at t=1.0ms)
alter V_ref pulse = [ 5.0 5.0 0 0 0 10m 20m ]
alter V_ctrl_load pulse = [ 1 0 1.0m 1u 1u 5m 10m ]
tran 1u 3m uic
wrdata results/ngspice_load.txt v(out) v(d) i(L_filt)

quit
.endcontrol
.end
